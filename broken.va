//  Resistor model with both thermal and flicker noise
//
//  This model demonstrates the wrong way to model flicker noise. It gives
//  correct results in noise analyses but the wrong results in pnoise analyses.
//  The issue is described in:
//
//     Flicker Noise Formulations in Verilog-A Compact Models
//     G. J. Coram, C. C. McAndrew, K. K.  Gullapalli, and K. S. Kundert
//     IEEE Transactions on CAD, vol. 39, no. 10, October 2020
//
//  DO NOT USE THIS MODEL.
//
//  It is provided only to demonstrate the wrong way to write a flicker noise
//  model.

`include "disciplines.vams"
`include "constants.vams"

module res_va(a,b);
  inout      a, b;
  electrical a, b;
  parameter real R  = 100.0    from (0.0:inf);
  parameter real KF =   1.0e-6 from [0.0:inf);
  parameter real AF =   2.0    from (0.1:inf);
  parameter real EF =   1.0    from (-inf:inf);

  analog begin : vaResistor
    real Ir, Pn;
    Ir      = V(a,b)/R;
    Pn      = KF*pow(abs(Ir), AF);
    I(a,b) <+ Ir;
    I(a,b) <+ white_noise(4.0*`P_K*$temperature/R, "thermal");
    I(a,b) <+ flicker_noise(Pn, EF, "flicker");
  end
endmodule
