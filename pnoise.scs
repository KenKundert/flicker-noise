// Resistor flicker noise simulations

simulator lang=spectre

ahdl_include "resistor.va"

model rref resistor kf=1.0e-6 af=2  // to match res_va

Vmod   (n 0) vsource type=sine dc=1.0 sinedc=0.0 ampl=100mV freq=131.072kHz
R1     (n 0) res_va
R2     (n 0) rref r=100.0

noise  noise start=4_Hz stop=4.194304MHz dec=2k oprobe=Vin
pss    pss fund=131.072kHz
pnoise pnoise start=4_Hz stop=4.194304MHz dec=2k maxsideband=10 oprobe=Vin
